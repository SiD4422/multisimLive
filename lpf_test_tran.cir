Circuit
V_V1 1 0 AC 1 SINE(0 1 1k)
R_R1 1 2 1k
C_C1 2 0 1u
.tran 0.1m 10m
.control
run
.endc
