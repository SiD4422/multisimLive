Circuit
V_V1 1 0 AC 1 SINE(0 1 1000)
R_R1 1 2 1k
C_C1 2 0 1u
.ac dec 100 1 100k
.control
run
set filetype=ascii
write /output.raw
.endc
